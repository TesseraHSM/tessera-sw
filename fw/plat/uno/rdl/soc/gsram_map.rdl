// Copyright (c) Microsoft Corporation.
// Licensed under the MIT License.
//
// GSRAM address map (io_gsram).
//
// Single unified address map at base 0x6100_0000 (2 MiB). Holds all
// shared-memory queues, DMA buffers, persistent stores, and the key
// vault. DTCM_IO_BUF is NOT here — it lives in dtcm_map.rdl.
//
// Region layout:
//   0x01000            UART lock (4 B, CP0 and CP1)
//   0x01110 - 0x012FC  BKS table (device-global, 12 × 41-byte entries)
//   0x012FC - 0x01360  FIPS provisioned keys (SP KDF key + CP mask key + flag)
//   0x01360 - 0x013C0  HSM seed table (UDS + FMC-CDI, 2 × 48-byte seeds)
//   0x027F8 - 0x03000  HSM debug-log ring (descriptor + 170 × 12-byte records)
//   0x07000            BOOT_STATUS (4 B)
//   0x07004 - 0x07114  Admin↔HSM IPC queues (indices + 2×2 ring slots)
//   0x07EA4 - 0x07FB4  HSM↔Admin IPC queues (indices + 2×2 ring slots)
//   0x0E440 - 0x0EF44  IIC queues (ISQ, ICQ, IO_SQ, ICQ tail shadow)
//   0x0F000 - 0x11824  Reserved: Admin (CP0) GDMA rings — do not place HSM data here
//   0x11840 - 0x11E44  OIC queues (OSQ, OCQ, IO_CQ, OCQ tail shadow)
//   0x12840 - 0x15048  GDMA queues (128 entries)
//   0x17400 - 0x19460  Bulk IIC/OIC queues (controller 1, channel 0)
//   0x19460 - 0x1A460  Bulk crypto per-IO scratch
//   0x1A460 - 0x1AB84  Bulk IIC/OIC rings (controller 1, channel 1)
//   0x20C58 - 0xA8D60  Heap (IO_META + SRAM_IO_BUF)
//   0xA9000 - 0xAAD40  Crypto command buffers (AES, UPKA, SHA)
//   0xAB000 - 0xAD800  BCP (CDMA) rings
//   0xAD800 - 0xADD00  PKA staged-command descriptors
//   0xADD00 - 0xB8000  Unused (former HSM code window)
//   0xB8000 - 0xB8041  FP bulk-key slot map (65 × 1-byte table bitmaps)
//   0xBB000 - 0xEBC00  Partition store
//   0xEBC00 - 0x16DC00 Key vault (65 × 8 KB tables)
//   0x16E000 - 0x1D0000 HSM executable code (self-tests, test hooks, KAT vectors)
//   0x1D0000 - 0x200000 Fastpath ML-DSA matrix cache
//
// Hardware alignment: UCD and GDMA hardware expect queue base
// addresses to be 32-byte (0x20) aligned.
//
// Ranges with no block: this file doesn't describe the complete GSRAM
// layout. Treat each range with no block as reserved: the HSP firmware,
// CP0, and other bus masters can use it. Before a new use of such a range,
// get approval from the owners of the HSP firmware. A new use can be a new,
// moved, or larger block, a linker script, or an address in code. A block
// that describes data the HSP firmware already defines for the CP cores,
// with the same offset, size, and purpose, isn't a new use. Give every
// block an explicit offset.


// ══════════════════════════════════════════════════════════════
// UART Lock (CP0 and CP1)
// ══════════════════════════════════════════════════════════════
//
// The HSP firmware already defines this 4-byte word at offset 0x1000
// (abs 0x6100_1000) as a lock for the CP cores, and clears it at reset.
// CP0 and CP1 share one UART, and as in the reference firmware, each core
// holds this lock while it prints one line. The block keeps the HSP
// firmware's offset, size, and purpose, so it isn't a new use of GSRAM.

reg uart_lock_t {
    name = "UART Lock";
    desc = "0 when free, 1 while CP0 or CP1 holds the lock.";
    field { sw = rw; hw = rw; } VAL[31:0] = 0x0;
};

// ══════════════════════════════════════════════════════════════
// BKS Table (device-global, SP-populated, read-only)
// ══════════════════════════════════════════════════════════════
//
// Mirrors the reference firmware's GsRamMemMap::bks_table at the
// identical GSRAM offset 0x1110 (abs 0x6100_1110). 12 packed 41-byte
// entries = 492 B (0x1EC):
//   entry[0]     = current BKS1  (entry[0].svn = current firmware SVN)
//   entry[1..10] = last ten SVNs' BKS1 (history)
//   entry[11]    = the single BKS2 (bks2_id is always 0)
// Each entry is packed { valid:u8, svn:[u8;8], bks:[u8;32] } and not
// word-aligned, so it is modeled as a byte-granular (memwidth = 8) mem;
// the typed valid/svn/bks split is owned by the bks_store driver.

mem bks_table_entry_t {
    desc = "Packed 41-byte BKS entry: valid(1) + svn(8) + bks(32).";
    mementries = 41;
    memwidth   = 8;
};


// ══════════════════════════════════════════════════════════════
// FIPS Provisioned Keys (SP-populated, secure-provisioning block)
// ══════════════════════════════════════════════════════════════
//
// Mirrors the reference firmware's GsRamMemMap FIPS provisioned keys
// block at GSRAM offset 0x12FC (abs 0x6100_12FC), immediately after the
// BKS table. A contiguous 100 B block matching the SP-side
// `struct fips_provisioned_keys` layout:
//   0x12FC - 0x132C  sp_fips_provisioned_keys  (48 B, SP KDF key, RO)
//   0x132C - 0x135C  cp_fips_provisioned_keys  (48 B, CP mask key, RW)
//   0x135C           fips_provisioned_keys_flag (1 B) — keys provisioned
//                    via the secure provisioning process
//   0x135D - 0x1360  reserved (3 B) — packs the block to a 4-byte tail
// The 48-byte key blobs are opaque key material, modeled as byte-granular
// (memwidth = 8) mems; the flag and its reserved tail share one 4-byte
// register so the block stays word-aligned at 0x1360.

mem fips_prov_key_t {
    desc = "48-byte FIPS provisioned key blob (SP KDF key / CP mask key).";
    mementries = 48;
    memwidth   = 8;
};

reg fips_prov_flag_t {
    regwidth = 32;
    desc = "FIPS provisioned-keys flag (byte 0) plus 3 reserved bytes.";
    field { sw = rw; hw = r; } FLAG[7:0] = 0x0;
    field { sw = rw; hw = r; } RSVD[31:8] = 0x0;
};


// ══════════════════════════════════════════════════════════════
// HSM Seed Table (device-rooted, SP-populated, read-only)
// ══════════════════════════════════════════════════════════════
//
// Mirrors the reference firmware's GsRamMemMap::hsm_seed_table at the
// identical GSRAM offset 0x1360 (abs 0x6100_1360), immediately after
// the FIPS provisioned keys block. 2 packed 48-byte entries = 96 B (0x60):
//   entry[0] = UDS seed      (firmware-state-independent device root)
//   entry[1] = FMC-CDI seed  (DICE-CDI / firmware-measurement-bound)
// Each entry is a bare 48-byte HMAC-SHA384 output written by the HSP
// during boot; there is no per-entry header. Modeled as a byte-granular
// (memwidth = 8) mem — the seed bytes are opaque key-derivation-key
// material consumed by the deterministic-keygen path, so no typed field
// split is imposed here.

mem hsm_seed_entry_t {
    desc = "48-byte device-rooted HSM seed (HMAC-SHA384 output).";
    mementries = 48;
    memwidth   = 8;
};


// ══════════════════════════════════════════════════════════════
// HSM Debug-Log Ring (CP1 writes records, the SP drains them)
// ══════════════════════════════════════════════════════════════
//
// Mirrors the reference firmware's CP1 debug-log ring at the identical
// GSRAM offsets 0x27F8 - 0x3000 (abs 0x6100_27F8 - 0x6100_3000). The SP
// drains it into the HSP debug log, so the layout is the record format
// shared with the HSP firmware:
//   0x27F8           buffer_size: 170 slots; CP1 writes it at boot
//   0x27FC           head: the next record the SP reads; the SP writes
//                    it, and CP1 zeroes it at boot
//   0x2800           tail: the next free slot; CP1 writes it
//   0x2804           overflows: records CP1 dropped because the ring was
//                    full; CP1 writes it
//   0x2808 - 0x3000  170 records of 12 bytes: the descriptor word
//                    (severity, component, message number, and a reserved
//                    zero byte), then two 32-bit values; little-endian
// One slot always stays empty, so the ring holds at most 169 records. The
// tsra_fw_uno_log_ring crate checks these offsets at compile time.

reg hsm_log_word_t {
    name = "HSM Debug-Log Ring Word";
    desc = "One 32-bit word of the HSM debug-log ring.";
    field { sw = rw; hw = rw; } VAL[31:0] = 0x0;
};

regfile hsm_log_record_t {
    name = "HSM Debug-Log Record";
    desc = "12-byte record: the descriptor word, then two 32-bit values.";
    hsm_log_word_t DESC   @ 0x0;
    hsm_log_word_t VALUE1 @ 0x4;
    hsm_log_word_t VALUE2 @ 0x8;
};


// ══════════════════════════════════════════════════════════════
// Boot Status
// ══════════════════════════════════════════════════════════════

reg boot_status_t {
    name = "Boot Status";
    desc = "HSM boot phase indicator. Written by HSM firmware, polled
            by Admin. Values: 0=NotStarted, 1=Done, 2=Run.";
    field { sw = rw; hw = r; } STATE[31:0] = 0x0;
};


// ══════════════════════════════════════════════════════════════
// Admin↔HSM IPC queues
// ══════════════════════════════════════════════════════════════

reg ipc_queue_index_t {
    name = "IPC Queue Index";
    desc = "Producer or consumer index for an IPC ring.";
    field { sw = rw; hw = rw; } VAL[31:0] = 0x0;
};

// IPC message slot: 16 DWORDs (64 bytes).
regfile ipc_message_t {
    name = "IPC Message";
    desc = "64-byte IPC message slot (16 × u32). First DWORD is the
            header (opcode, response bit, status, length). Remaining
            15 DWORDs are payload.";
    io_sq_dw_t DW0  @ 0x00;
    io_sq_dw_t DW1  @ 0x04;
    io_sq_dw_t DW2  @ 0x08;
    io_sq_dw_t DW3  @ 0x0C;
    io_sq_dw_t DW4  @ 0x10;
    io_sq_dw_t DW5  @ 0x14;
    io_sq_dw_t DW6  @ 0x18;
    io_sq_dw_t DW7  @ 0x1C;
    io_sq_dw_t DW8  @ 0x20;
    io_sq_dw_t DW9  @ 0x24;
    io_sq_dw_t DW10 @ 0x28;
    io_sq_dw_t DW11 @ 0x2C;
    io_sq_dw_t DW12 @ 0x30;
    io_sq_dw_t DW13 @ 0x34;
    io_sq_dw_t DW14 @ 0x38;
    io_sq_dw_t DW15 @ 0x3C;
};


// ══════════════════════════════════════════════════════════════
// IIC / OIC queue structures
// ══════════════════════════════════════════════════════════════

// -- ISQ Entry - 8 bytes (2 DWORDs) --

reg isq_addr_lo_t {
    name = "ISQ Address Low";
    desc = "Low 32 bits of the host SQE address.";
    field { sw = rw; hw = r; } ADDR[31:0] = 0x0;
};

reg isq_addr_hi_t {
    name = "ISQ Address High";
    desc = "High 32 bits of the host SQE address.";
    field { sw = rw; hw = r; } ADDR[31:0] = 0x0;
};

regfile isq_entry_t {
    name = "ISQ Entry";
    desc = "Inbound Submission Queue entry — 8 bytes. Points to the
             host-side SQE that the DMA engine fetches into IO_SQ.";
    isq_addr_lo_t ADDR_LO @ 0x0;
    isq_addr_hi_t ADDR_HI @ 0x4;
};

// -- ICQ Entry - 16 bytes (4 DWORDs) --

reg icq_info_t {
    name = "ICQ Info";
    desc = "Inbound Completion Queue info: status and interface select.";
    field { sw = rw; hw = r; } STATUS[7:0] = 0x0;
    field { sw = rw; hw = r; } IFC_SLCT[15:8] = 0x0;
    field { sw = rw; hw = r; } RSVD[31:16] = 0x0;
};

reg icq_index_t {
    name = "ICQ Index";
    desc = "ISQ slot index being completed.";
    field { sw = rw; hw = r; } INDEX[15:0] = 0x0;
    field { sw = rw; hw = r; } RSVD[31:16] = 0x0;
};

regfile icq_entry_t {
    name = "ICQ Entry";
    desc = "Inbound Completion Queue entry — 16 bytes.";
    isq_addr_lo_t  ADDR_LO @ 0x0;
    isq_addr_hi_t  ADDR_HI @ 0x4;
    icq_info_t INFO    @ 0x8;
    icq_index_t INDEX  @ 0xC;
};

// -- IO SQ Entry - 64 bytes (16 DWORDs) --

reg io_sq_dw_t {
    name = "IO SQ DWORD";
    desc = "One DWORD of an IO Submission Queue entry.";
    field {} VAL[31:0] = 0x0;
};

regfile io_sq_entry_t {
    name = "IO SQ Entry";
    desc = "64-byte command descriptor DMA'd from host.";
    io_sq_dw_t DW0  @ 0x00;
    io_sq_dw_t DW1  @ 0x04;
    io_sq_dw_t DW2  @ 0x08;
    io_sq_dw_t DW3  @ 0x0C;
    io_sq_dw_t DW4  @ 0x10;
    io_sq_dw_t DW5  @ 0x14;
    io_sq_dw_t DW6  @ 0x18;
    io_sq_dw_t DW7  @ 0x1C;
    io_sq_dw_t DW8  @ 0x20;
    io_sq_dw_t DW9  @ 0x24;
    io_sq_dw_t DW10 @ 0x28;
    io_sq_dw_t DW11 @ 0x2C;
    io_sq_dw_t DW12 @ 0x30;
    io_sq_dw_t DW13 @ 0x34;
    io_sq_dw_t DW14 @ 0x38;
    io_sq_dw_t DW15 @ 0x3C;
};

// -- Queue shadow (single DWORD) --

reg queue_shadow_t {
    name = "Queue Shadow";
    desc = "DMA shadow of a queue producer/consumer index.";
    field { sw = rw; hw = rw; } VAL[31:0] = 0x0;
};

// -- IO Meta Entry - 8 bytes (2 DWORDs) --

reg io_meta_ctlr_t {
    name = "IO Meta Controller";
    desc = "Controller ID for this IO slot.";
    field { sw = rw; hw = na; } CONTROLLER_ID[15:0] = 0x0;
    field { sw = rw; hw = na; } RSVD[31:16] = 0x0;
};

reg io_meta_queue_t {
    name = "IO Meta Queue";
    desc = "Queue ID and index for this IO slot.";
    field { sw = rw; hw = na; } QUEUE_ID[15:0] = 0x0;
    field { sw = rw; hw = na; } QUEUE_INDEX[31:16] = 0x0;
};

regfile io_meta_entry_t {
    name = "IO Meta Entry";
    desc = "Per-slot metadata written at recv time. One per IO_SQ slot.";
    io_meta_ctlr_t  CTLR  @ 0x0;
    io_meta_queue_t QUEUE  @ 0x4;
};

// -- OSQ Entry - 16 bytes (4 DWORDs) --

reg osq_desc_t {
    name = "OSQ Descriptor";
    desc = "Outbound descriptor: queue IDs and credits.";
    field { sw = rw; hw = r; } RX_QUEUE_ID[7:0] = 0x0;
    field { sw = rw; hw = r; } RX_CREDIT[15:8] = 0x0;
    field { sw = rw; hw = r; } TX_QUEUE_ID[23:16] = 0x0;
    field { sw = rw; hw = r; } AXI_ID[31:24] = 0x0;
};

reg osq_tag_t {
    name = "OSQ Tag";
    desc = "16-bit tag + control field.";
    field { sw = rw; hw = r; } TAG[15:0] = 0x0;
    field { sw = rw; hw = r; } CONTROL[31:16] = 0x0;
};

regfile osq_entry_t {
    name = "OSQ Entry";
    desc = "Outbound Submission Queue entry — 16 bytes.";
    isq_addr_lo_t ADDR_LO @ 0x0;
    isq_addr_hi_t ADDR_HI @ 0x4;
    osq_desc_t    DESC    @ 0x8;
    osq_tag_t     TAG     @ 0xC;
};

// -- OCQ Entry - 16 bytes (4 DWORDs) --

reg ocq_info_t {
    name = "OCQ Info (DW2)";
    desc = "Routing info: queue_index, queue_id, axi_id.";
    field { sw = rw; hw = r; } QUEUE_INDEX[15:0] = 0x0;
    field { sw = rw; hw = r; } QUEUE_ID[23:16] = 0x0;
    field { sw = rw; hw = r; } AXI_ID[31:24] = 0x0;
};

reg ocq_tag_t {
    name = "OCQ Tag (DW3)";
    desc = "Tag and completion status.";
    field { sw = rw; hw = r; } TAG[15:0] = 0x0;
    field { sw = rw; hw = r; } RSVD0[23:16] = 0x0;
    field { sw = rw; hw = r; } STATUS[31:24] = 0x0;
};

regfile ocq_entry_t {
    name = "OCQ Entry";
    desc = "Outbound Completion Queue entry — 16 bytes.";
    isq_addr_lo_t ADDR_LO @ 0x0;
    isq_addr_hi_t ADDR_HI @ 0x4;
    ocq_info_t    INFO    @ 0x8;
    ocq_tag_t     TAG     @ 0xC;
};

// -- IO CQ Entry - 16 bytes (4 DWORDs) --

reg io_cq_dw_t {
    name = "IO CQ DWORD";
    desc = "One DWORD of an IO Completion Queue entry.";
    field {} VAL[31:0] = 0x0;
};

regfile io_cq_entry_t {
    name = "IO CQ Entry";
    desc = "16-byte completion status written by firmware.";
    io_cq_dw_t DW0 @ 0x0;
    io_cq_dw_t DW1 @ 0x4;
    io_cq_dw_t DW2 @ 0x8;
    io_cq_dw_t DW3 @ 0xC;
};

// -- Bulk IO SQ Entry - 128 bytes (32 DWORDs) --

regfile bulk_io_sq_entry_t {
    name = "Bulk IO SQ Entry";
    desc = "128-byte bulk (fast-path) SQE plus aux, DMA'd from host.";
    io_sq_dw_t DW0  @ 0x00;
    io_sq_dw_t DW1  @ 0x04;
    io_sq_dw_t DW2  @ 0x08;
    io_sq_dw_t DW3  @ 0x0C;
    io_sq_dw_t DW4  @ 0x10;
    io_sq_dw_t DW5  @ 0x14;
    io_sq_dw_t DW6  @ 0x18;
    io_sq_dw_t DW7  @ 0x1C;
    io_sq_dw_t DW8  @ 0x20;
    io_sq_dw_t DW9  @ 0x24;
    io_sq_dw_t DW10 @ 0x28;
    io_sq_dw_t DW11 @ 0x2C;
    io_sq_dw_t DW12 @ 0x30;
    io_sq_dw_t DW13 @ 0x34;
    io_sq_dw_t DW14 @ 0x38;
    io_sq_dw_t DW15 @ 0x3C;
    io_sq_dw_t DW16 @ 0x40;
    io_sq_dw_t DW17 @ 0x44;
    io_sq_dw_t DW18 @ 0x48;
    io_sq_dw_t DW19 @ 0x4C;
    io_sq_dw_t DW20 @ 0x50;
    io_sq_dw_t DW21 @ 0x54;
    io_sq_dw_t DW22 @ 0x58;
    io_sq_dw_t DW23 @ 0x5C;
    io_sq_dw_t DW24 @ 0x60;
    io_sq_dw_t DW25 @ 0x64;
    io_sq_dw_t DW26 @ 0x68;
    io_sq_dw_t DW27 @ 0x6C;
    io_sq_dw_t DW28 @ 0x70;
    io_sq_dw_t DW29 @ 0x74;
    io_sq_dw_t DW30 @ 0x78;
    io_sq_dw_t DW31 @ 0x7C;
};

// -- Bulk IO CQ Entry - 64 bytes (16 DWORDs) --

regfile bulk_io_cq_entry_t {
    name = "Bulk IO CQ Entry";
    desc = "64-byte bulk (fast-path) completion written by firmware.";
    io_cq_dw_t DW0  @ 0x00;
    io_cq_dw_t DW1  @ 0x04;
    io_cq_dw_t DW2  @ 0x08;
    io_cq_dw_t DW3  @ 0x0C;
    io_cq_dw_t DW4  @ 0x10;
    io_cq_dw_t DW5  @ 0x14;
    io_cq_dw_t DW6  @ 0x18;
    io_cq_dw_t DW7  @ 0x1C;
    io_cq_dw_t DW8  @ 0x20;
    io_cq_dw_t DW9  @ 0x24;
    io_cq_dw_t DW10 @ 0x28;
    io_cq_dw_t DW11 @ 0x2C;
    io_cq_dw_t DW12 @ 0x30;
    io_cq_dw_t DW13 @ 0x34;
    io_cq_dw_t DW14 @ 0x38;
    io_cq_dw_t DW15 @ 0x3C;
};


// ══════════════════════════════════════════════════════════════
// GDMA queue structures
// ══════════════════════════════════════════════════════════════

reg gdma_sq_dw_t {
    name = "GDMA SQ DWORD";
    desc = "One DWORD of a GDMA Submission Queue entry.";
    field {} VAL[31:0] = 0x0;
};

regfile gdma_sq_entry_t {
    name = "GDMA SQ Entry";
    desc = "64-byte GDMA submission descriptor.";
    gdma_sq_dw_t DW0  @ 0x00;
    gdma_sq_dw_t DW1  @ 0x04;
    gdma_sq_dw_t DW2  @ 0x08;
    gdma_sq_dw_t DW3  @ 0x0C;
    gdma_sq_dw_t DW4  @ 0x10;
    gdma_sq_dw_t DW5  @ 0x14;
    gdma_sq_dw_t DW6  @ 0x18;
    gdma_sq_dw_t DW7  @ 0x1C;
    gdma_sq_dw_t DW8  @ 0x20;
    gdma_sq_dw_t DW9  @ 0x24;
    gdma_sq_dw_t DW10 @ 0x28;
    gdma_sq_dw_t DW11 @ 0x2C;
    gdma_sq_dw_t DW12 @ 0x30;
    gdma_sq_dw_t DW13 @ 0x34;
    gdma_sq_dw_t DW14 @ 0x38;
    gdma_sq_dw_t DW15 @ 0x3C;
};

reg gdma_cq_status_t {
    name = "CQ Status (DW0)";
    desc = "Completion status and TAG echoed from SQ entry.";
    field { sw = rw; hw = rw; } SUCCESS[0:0] = 0x0;
    field { sw = rw; hw = rw; } RSVD0[15:1] = 0x0;
    field { sw = rw; hw = rw; } TAG[31:16] = 0x0;
};

reg gdma_cq_rsvd_t {
    name = "GDMA CQ Reserved";
    desc = "Reserved DWORD in GDMA CQ entry.";
    field {} VAL[31:0] = 0x0;
};

regfile gdma_cq_entry_t {
    name = "GDMA CQ Entry";
    desc = "16-byte GDMA completion entry.";
    gdma_cq_status_t STATUS @ 0x0;
    gdma_cq_rsvd_t   RSVD0 @ 0x4;
    gdma_cq_rsvd_t   RSVD1 @ 0x8;
    gdma_cq_rsvd_t   RSVD2 @ 0xC;
};


// ══════════════════════════════════════════════════════════════
// Crypto command descriptors (AES, UPKA, SHA)
// ══════════════════════════════════════════════════════════════

// -- AES Command Entry - 24 bytes (6 DWORDs) --

// -- BCP (CDMA) queue entries --
//
// Raw DWORDs; the driver owns the bit layouts (silicon `CdmaSqCmdDescr_t`,
// `CdmaCqCmdDescr_t`, and the 128-byte host command + GCM/XTS aux command
// the engine reads as a DFL element).

regfile bcp_sqe_t {
    name = "BCP SQE";
    desc = "16-byte CDMA submission queue entry.";
    io_sq_dw_t DW0 @ 0x00;
    io_sq_dw_t DW1 @ 0x04;
    io_sq_dw_t DW2 @ 0x08;
    io_sq_dw_t DW3 @ 0x0C;
};

regfile bcp_cqe_t {
    name = "BCP CQE";
    desc = "8-byte CDMA completion queue entry.";
    io_sq_dw_t DW0 @ 0x00;
    io_sq_dw_t DW1 @ 0x04;
};

regfile bcp_dfl_entry_t {
    name = "BCP DFL Entry";
    desc = "128-byte CDMA descriptor fetch list element.";
    io_sq_dw_t DW0  @ 0x00;
    io_sq_dw_t DW1  @ 0x04;
    io_sq_dw_t DW2  @ 0x08;
    io_sq_dw_t DW3  @ 0x0C;
    io_sq_dw_t DW4  @ 0x10;
    io_sq_dw_t DW5  @ 0x14;
    io_sq_dw_t DW6  @ 0x18;
    io_sq_dw_t DW7  @ 0x1C;
    io_sq_dw_t DW8  @ 0x20;
    io_sq_dw_t DW9  @ 0x24;
    io_sq_dw_t DW10 @ 0x28;
    io_sq_dw_t DW11 @ 0x2C;
    io_sq_dw_t DW12 @ 0x30;
    io_sq_dw_t DW13 @ 0x34;
    io_sq_dw_t DW14 @ 0x38;
    io_sq_dw_t DW15 @ 0x3C;
    io_sq_dw_t DW16 @ 0x40;
    io_sq_dw_t DW17 @ 0x44;
    io_sq_dw_t DW18 @ 0x48;
    io_sq_dw_t DW19 @ 0x4C;
    io_sq_dw_t DW20 @ 0x50;
    io_sq_dw_t DW21 @ 0x54;
    io_sq_dw_t DW22 @ 0x58;
    io_sq_dw_t DW23 @ 0x5C;
    io_sq_dw_t DW24 @ 0x60;
    io_sq_dw_t DW25 @ 0x64;
    io_sq_dw_t DW26 @ 0x68;
    io_sq_dw_t DW27 @ 0x6C;
    io_sq_dw_t DW28 @ 0x70;
    io_sq_dw_t DW29 @ 0x74;
    io_sq_dw_t DW30 @ 0x78;
    io_sq_dw_t DW31 @ 0x7C;
};

regfile aes_cmd_entry_t {
    name = "AES Command Entry";
    desc = "24-byte AES command descriptor.";
    io_sq_dw_t CMD_CODE   @ 0x00;
    io_sq_dw_t RESULT     @ 0x04;
    io_sq_dw_t BYTE_COUNT @ 0x08;
    io_sq_dw_t MESSAGE    @ 0x0C;
    io_sq_dw_t KEY        @ 0x10;
    io_sq_dw_t IV         @ 0x14;
};

// -- UPKA Command Entry - 20 bytes (5 DWORDs) --

regfile upka_cmd_entry_t {
    name = "UPKA Command Entry";
    desc = "20-byte PKA command descriptor (per-engine or per-ticket slot).";
    io_sq_dw_t COMMAND_CODE @ 0x00;
    io_sq_dw_t RESULT_ADDR  @ 0x04;
    io_sq_dw_t ARG1_ADDR    @ 0x08;
    io_sq_dw_t ARG2_ADDR    @ 0x0C;
    io_sq_dw_t ARG3_ADDR    @ 0x10;
};

// -- SHA Command Entry - 32 bytes (8 DWORDs) --

regfile sha_cmd_entry_t {
    name = "SHA Command Entry";
    desc = "32-byte SHA command descriptor.";
    io_sq_dw_t SHA_COMMAND     @ 0x00;
    io_sq_dw_t SHA_RESULT      @ 0x04;
    io_sq_dw_t SHA_MSG_ADDR    @ 0x08;
    io_sq_dw_t SHA_MSG_LEN     @ 0x0C;
    io_sq_dw_t SHA_INIT_DIGEST @ 0x10;
    io_sq_dw_t SHA_KEY_ADDR    @ 0x14;
    io_sq_dw_t PASS_MSG_BUFF   @ 0x18;
    io_sq_dw_t SHA_KEY_LEN     @ 0x1C;
};


// ══════════════════════════════════════════════════════════════
// Heap structures (IO_META + SRAM_IO_BUF)
// ══════════════════════════════════════════════════════════════

mem sram_io_buf_t {
    desc = "16KB per-slot DMA buffer for the bump allocator. Sized to
            ZERO (16 KB) so a full-slot GDMA scrub is a single transfer
            from the read-as-zero window rather than two.";
    mementries = 4096;
    memwidth = 32;
};

mem bulk_scratch_t {
    desc = "128-byte per-bulk-IO scratch (AES blocks and the GCM tail)
            that bulk IOs use instead of the per-IO bump allocator.";
    mementries = 32;
    memwidth = 32;
};


// ══════════════════════════════════════════════════════════════
// Partition Store + Key Vault
// ══════════════════════════════════════════════════════════════

// ── FP bulk-key slot map ────────────────────────────────────────
//
// Mirrors the reference firmware's GsRamMemMap::cdma_key_vault_meta_data
// at the identical GSRAM offset 0xB8000 (abs 0x610B_8000). One byte per
// fast-path key table (65); bit i set = slot i of that table is held by a
// bulk key (only bits 0..=6 are used). Kept in GSRAM, like the key vault
// whose bulk-key handles reference these slots, so it survives warm and
// fw-update resets. Byte-granular (memwidth = 8); the bit layout is owned
// by the vault driver.
//
// IDFU contract: an impactless firmware update keeps this
// region's contents and attaches to the running IO queues. Changing the
// layout of the partition store, key vault, FP bulk-key slot map, or IO
// pool (IIC/OIC queues and IO_SQ/IO_CQ buffers) therefore requires bumping
// `FW_VERSION_IDFU` (manticore `version.h`), so SP performs an impactful
// update instead.

mem fp_slot_map_t {
    desc = "FP bulk-key slot occupancy: one 7-bit bitmap byte per FP table.";
    mementries = 65;
    memwidth   = 8;
};

// ── Partition persistent store ──────────────────────────────────
//
// Per-partition persistent store, one entry per partition (cardinality
// 65, one slot per key-vault table index / controller id), each a
// 3072-byte (0xC00) region mirroring the reference firmware's
// HsmPartPersistentStore with Uno-specific working-state fields appended
// into its trailing reserved region. The typed layout and the only
// access path are owned by the part_store driver — the PAL no longer
// reads or writes this GSRAM directly.

reg part_store_word_t {
    name = "Partition Store Word";
    desc = "One 32-bit word of the per-partition persistent store. The
            typed field layout (reference HsmPartPersistentStore plus the
            Uno-specific working-state fields) is owned by the part_store
            driver, not described here.";
    field { sw = rw; hw = na; } VAL[31:0] = 0x0;
};

// One partition persistent-store entry: an opaque 3072-byte (0xC00)
// region, 768 words. The typed layout lives in the part_store driver,
// which owns the only access path (the PAL no longer touches GSRAM
// directly).
addrmap part_store_t {
    name = "Partition Persistent Store";
    desc = "Per-partition persistent store (3072 B), mirroring the reference
            firmware's HsmPartPersistentStore with Uno-specific fields
            appended into the trailing reserved region.";

    default hw = na;
    default sw = rw;

    part_store_word_t DATA[768] @ 0x00 += 0x04;  // 0x000 - 0xC00
};

// ── Key vault ───────────────────────────────────────────────────
//
// Typed mirror of the reference firmware's per-partition key store, so
// key IDs, sizes, and on-storage layout are interchangeable. One table
// is TOTAL_TABLE_LEN = 8192 B and holds 128 metadata entries, a
// block-allocator bitmap, and a key-data blob region:
//
//   0x0000 - 0x0400  ENTRY[128]  (128 × 8-byte PhysicalEntry metadata)
//   0x0400 - 0x0480  BITMAP[32]  (used-block tracker, 32 × u32)
//   0x0480 - 0x2000  BLOB        (7040-byte key-data region)
//
// Within BLOB, each key occupies an 8-byte-aligned block laid out as
// [32-byte attributes][key bytes]; PhysicalEntry.OFFSET is the block
// index (× 8 = byte offset into BLOB).

// One 8-byte vault metadata entry (mirrors the reference PhysicalEntry).
reg pe_dw0_t {
    name = "Vault Entry DW0";
    desc = "PhysicalEntry low DWORD: blob block offset + flags.";
    field { sw = rw; hw = na; } OFFSET[15:0]   = 0x0;  // blob block index
    field { sw = rw; hw = na; } DISABLED[16:16] = 0x0; // EntryFlags bit 0
    field { sw = rw; hw = na; } SESSION[17:17]  = 0x0; // EntryFlags bit 1
    field { sw = rw; hw = na; } FLAGS_RSVD[31:18] = 0x0;
};

reg pe_dw1_t {
    name = "Vault Entry DW1";
    desc = "PhysicalEntry high DWORD: session id / key tag, kind, app id.";
    field { sw = rw; hw = na; } SESSION_OR_TAG[15:0] = 0x0;
    field { sw = rw; hw = na; } KIND[23:16]          = 0x0; // HsmVaultKeyKind
    field { sw = rw; hw = na; } APP_ID[31:24]        = 0x0;
};

regfile physical_entry_t {
    name = "Vault Physical Entry";
    desc = "8-byte key metadata entry.";
    pe_dw0_t DW0 @ 0x0;
    pe_dw1_t DW1 @ 0x4;
};

// One word of the per-table used-block allocator bitmap.
reg used_block_t {
    name = "Used Block Tracker Word";
    desc = "32 blob-block occupancy bits.";
    field { sw = rw; hw = na; } BITS[31:0] = 0x0;
};

// Key-data blob region (7040 B = TOTAL_TABLE_LEN - 1152).
mem key_blob_t {
    desc = "Per-table key-data blob region.";
    mementries = 1760;  // 7040 / 4
    memwidth = 32;
};

// ── HSM executable code ─────────────────────────────────────────
//
// The only executable GSRAM region. 1SP loads the HSM image's
// `.gsram_text` (self-test/test-hook code) and `.gsram_rodata` (their
// known-answer vectors, kept in a separate, 32 B-aligned output section)
// here before releasing CP1, and the SP preserves it across warm resets, so
// its bounds must match HSM_CODE_GSRAM_ADDRESS / HSM_CODE_GSRAM_SIZE in
// manticore sp/src/dc_scm/rot_memory_map.h.
//
// It is the GSRAM freed when TOTAL_TABLE_LEN dropped from 14336 B to
// 8192 B (65 × 6 KB), taken as one contiguous window from the first 4 KB
// boundary after the vault up to FP_DSA_CACHE, so both sections can keep
// growing in place. The previous 60 KB code window at 0xA9000 is unused.
mem hsm_code_t {
    desc = "Executable HSM code (self-tests, test hooks, known-answer vectors), loaded by 1SP.";
    mementries = 401408; // 0x16E000..0x1D0000
    memwidth = 8;
};

// Fastpath ML-DSA matrix cache (192 KB).  Carved off the tail of the key
// vault when TOTAL_TABLE_LEN dropped to 14336 B; it runs 0x1D0000 -
// 0x200000 (64 KB-aligned), directly above HSM_CODE.  Declared here so
// neither the vault nor HSM_CODE can grow over it and so the FP firmware
// has a generated base to reference instead of a hard-coded address.
// Mirrors cp/hsm's `rsvd_fp_dsa_cache`.
mem fp_dsa_cache_t {
    desc = "Fastpath ML-DSA matrix spill cache (3 cores x 64 KB).";
    mementries = 49152;  // 196608 / 4
    memwidth = 32;
};

// One 8192-byte vault table.
addrmap key_vault_table_t {
    name = "Key Vault Table";
    desc = "One 8192-byte vault table: metadata + bitmap + blob.";

    default hw = na;
    default sw = rw;

    physical_entry_t ENTRY[128]  @ 0x0000 += 0x08;  // 0x0000 - 0x0400
    used_block_t     BITMAP[32]  @ 0x0400 += 0x04;  // 0x0400 - 0x0480
    key_blob_t       BLOB        @ 0x0480;          // 0x0480 - 0x2000
};


// ══════════════════════════════════════════════════════════════
// Address Map
// ══════════════════════════════════════════════════════════════

addrmap io_gsram {
    name = "IO GSRAM";
    desc = "Unified GSRAM address map (2 MiB at 0x6100_0000).";

    default hw = na;
    default sw = rw;

    // ─── UART lock (CP0 and CP1 each hold it while printing one line) ───
    uart_lock_t      UART_LOCK          @ 0x01000;

    // ─── BKS table (device-global, SP-populated): 12 × 41-byte entries ───
    bks_table_entry_t BKS_TABLE[12]    @ 0x01110 += 0x29;  // 0x1110 - 0x12FC

    // ─── FIPS provisioned keys (SP-populated): 100-byte block ───
    //   SP KDF key (RO) + CP mask key (RW) + provisioned flag (+ reserved)
    fips_prov_key_t  SP_FIPS_PROVISIONED_KEYS @ 0x012FC += 0x30;  // 0x12FC - 0x132C
    fips_prov_key_t  CP_FIPS_PROVISIONED_KEYS @ 0x0132C += 0x30;  // 0x132C - 0x135C
    fips_prov_flag_t FIPS_PROVISIONED_KEYS_FLAG @ 0x0135C;        // 0x135C - 0x1360

    // ─── HSM seed table (device-rooted, SP-populated): 2 × 48-byte seeds ───
    //   [0] = UDS seed (firmware-state-independent)
    //   [1] = FMC-CDI seed (firmware-measurement-bound)
    hsm_seed_entry_t HSM_SEED_TABLE[2] @ 0x01360 += 0x30;  // 0x1360 - 0x13C0

    // ─── HSM debug-log ring (CP1 writes records, the SP drains them) ───
    hsm_log_word_t   HSM_LOG_BUFFER_SIZE  @ 0x027F8;
    hsm_log_word_t   HSM_LOG_HEAD         @ 0x027FC;
    hsm_log_word_t   HSM_LOG_TAIL         @ 0x02800;
    hsm_log_word_t   HSM_LOG_OVERFLOWS    @ 0x02804;
    hsm_log_record_t HSM_LOG_RECORDS[170] @ 0x02808 += 0x0C;  // 0x2808 - 0x3000

    // ─── Boot ───
    boot_status_t    BOOT_STATUS        @ 0x07000;

    // ─── Admin↔HSM IPC (depth=2, msg_len=16 DWORDs) ───
    // From HSM's perspective: RX = Admin writes / HSM reads,
    //                         TX = HSM writes / Admin reads.
    ipc_queue_index_t IPC_ADMIN_HSM_RX_PI   @ 0x07004;
    ipc_queue_index_t IPC_ADMIN_HSM_RX_CI   @ 0x07008;
    ipc_queue_index_t IPC_ADMIN_HSM_TX_PI   @ 0x0700C;
    ipc_queue_index_t IPC_ADMIN_HSM_TX_CI   @ 0x07010;
    ipc_message_t     IPC_ADMIN_HSM_RX_RING[2] @ 0x07014 += 0x40;
    ipc_message_t     IPC_ADMIN_HSM_TX_RING[2] @ 0x07094 += 0x40;

    // ─── HSM↔Admin IPC (depth=2, msg_len=16 DWORDs) ───
    // The HSM-initiated channel: HSM is the requestor, Admin the
    // responder. Mirrors the reference `hsm_to_admin_ipc_*` fields,
    // which the Admin core reads at these exact absolute addresses.
    //
    // Unlike the Admin↔HSM block above, these names need no
    // perspective flip: the reference names that channel from the
    // requestor's side, and here the requestor is us.
    //
    // Field order also differs from the block above — the reference
    // lays this channel out as CI before PI, with each ring placed
    // directly after its own index pair. Preserved verbatim.
    //
    ipc_queue_index_t IPC_HSM_ADMIN_TX_CI   @ 0x07EA4;
    ipc_queue_index_t IPC_HSM_ADMIN_TX_PI   @ 0x07EA8;
    ipc_message_t     IPC_HSM_ADMIN_TX_RING[2] @ 0x07EAC += 0x40;
    ipc_queue_index_t IPC_HSM_ADMIN_RX_CI   @ 0x07F2C;
    ipc_queue_index_t IPC_HSM_ADMIN_RX_PI   @ 0x07F30;
    ipc_message_t     IPC_HSM_ADMIN_RX_RING[2] @ 0x07F34 += 0x40;

    // ─── IIC (Inbound IO) — 0x20-aligned ───
    isq_entry_t      ISQ[32]            @ 0x0E440 += 0x08;
    icq_entry_t      ICQ[32]            @ 0x0E540 += 0x10;
    io_sq_entry_t    IO_SQ[32]          @ 0x0E740 += 0x40;
    queue_shadow_t   ICQ_TAIL_SHADOW    @ 0x0EF40;

    // ─── OIC (Outbound IO) — 0x20-aligned ───
    osq_entry_t      OSQ[32]            @ 0x11840 += 0x10;
    ocq_entry_t      OCQ[32]            @ 0x11A40 += 0x10;
    io_cq_entry_t    IO_CQ[32]          @ 0x11C40 += 0x10;
    queue_shadow_t   OCQ_TAIL_SHADOW    @ 0x11E40;

    // ─── GDMA — 0x20-aligned. The SQ head shadow is the word after the CQ
    // tail shadow. ───
    gdma_sq_entry_t  GDMA_SQ[128]       @ 0x12840 += 0x40;
    gdma_cq_entry_t  GDMA_CQ[128]       @ 0x14840 += 0x10;
    queue_shadow_t   GDMA_CQ_TAIL_SHADOW @ 0x15040;

    // 0x15048 - 0x17400 is unused; the 64-entry BCP rings did not fit.

    // ─── Bulk IIC/OIC (controller 1, channel 0) — 0x20-aligned; inside
    // the CDMA window ───
    isq_entry_t        BULK_ISQ[32]             @ 0x17400 += 0x08;  // 0x17400 - 0x17500
    icq_entry_t        BULK_ICQ[32]             @ 0x17500 += 0x10;  // 0x17500 - 0x17700
    queue_shadow_t     BULK_ICQ_TAIL_SHADOW     @ 0x17700;
    bulk_io_sq_entry_t BULK_IO_SQ[32]           @ 0x17720 += 0x80;  // 0x17720 - 0x18720
    osq_entry_t        BULK_OSQ[32]             @ 0x18720 += 0x10;  // 0x18720 - 0x18920
    ocq_entry_t        BULK_OCQ[32]             @ 0x18920 += 0x10;  // 0x18920 - 0x18B20
    queue_shadow_t     BULK_OCQ_TAIL_SHADOW     @ 0x18B20;
    bulk_io_cq_entry_t BULK_IO_CQ[32]           @ 0x18B60 += 0x40;  // 0x18B60 - 0x19360
    io_meta_entry_t    BULK_IO_META[32]         @ 0x19360 += 0x08;  // 0x19360 - 0x19460

    // ─── Bulk crypto per-IO scratch; inside the CDMA / GDMA window. Must
    // end before 0x1AC58 (Admin heap). ───
    bulk_scratch_t     BULK_SCRATCH[32]         @ 0x19460 += 0x80;  // 0x19460 - 0x1A460

    // ─── Bulk IIC/OIC rings (controller 1, channel 1: the queues of the
    // 65th function resource) — 0x20-aligned. The channel shares
    // BULK_IO_SQ / BULK_IO_CQ / BULK_IO_META / BULK_SCRATCH with channel 0,
    // each posting its own range of those slots. Must end before 0x1AC58
    // (Admin heap). ───
    isq_entry_t        BULK_FP2_ISQ[32]         @ 0x1A460 += 0x08;  // 0x1A460 - 0x1A560
    icq_entry_t        BULK_FP2_ICQ[32]         @ 0x1A560 += 0x10;  // 0x1A560 - 0x1A760
    queue_shadow_t     BULK_FP2_ICQ_TAIL_SHADOW @ 0x1A760;
    osq_entry_t        BULK_FP2_OSQ[32]         @ 0x1A780 += 0x10;  // 0x1A780 - 0x1A980
    ocq_entry_t        BULK_FP2_OCQ[32]         @ 0x1A980 += 0x10;  // 0x1A980 - 0x1AB80
    queue_shadow_t     BULK_FP2_OCQ_TAIL_SHADOW @ 0x1AB80;

    // ─── Heap (per-IO buffers) — 34 SRAM slots: 0..31 host (IIC), 32 admin,
    //     33 self-test (CAST). IO_META stays 33: only host+admin slots carry
    //     per-IO metadata (controller/queue id); the self-test slot never uses
    //     io_meta() (it does not ride the host IO path), so it needs no entry.
    //     Keeping IO_META at 33 also preserves SRAM_IO_BUF's 32-byte alignment
    //     at 0x20D60 (growing IO_META would shift SRAM_IO_BUF off alignment). ──
    io_meta_entry_t  IO_META[33]         @ 0x20C58 += 0x08;
    sram_io_buf_t    SRAM_IO_BUF[34]     @ 0x20D60 += 0x4000;

    // ─── Crypto command buffers, in the former HSM code window (HSM_CODE
    // moved above the key vault); 0xADD00 - 0xB8000 is unused. ───
    aes_cmd_entry_t  AES_CMD[128]        @ 0xA9000 += 0x18;   // 0xA9000 - 0xA9C00
    upka_cmd_entry_t UPKA_ENGINE_CMD[16] @ 0xA9C00 += 0x14;   // 0xA9C00 - 0xA9D40
    sha_cmd_entry_t  SHA_CMD[128]        @ 0xA9D40 += 0x20;   // 0xA9D40 - 0xAAD40

    // ─── BCP (CDMA) rings — HSM-owned; inside the GSRAM window the CDMA
    // may master (0x0F000 - 0xB8000) ───
    bcp_sqe_t        BCP_SQ[64]          @ 0xAB000 += 0x10;   // 0xAB000 - 0xAB400
    bcp_cqe_t        BCP_CQ[64]          @ 0xAB400 += 0x08;   // 0xAB400 - 0xAB600
    queue_shadow_t   BCP_SQ_CI_SHADOW    @ 0xAB600;
    queue_shadow_t   BCP_CQ_PI_SHADOW    @ 0xAB604;

    // The one PKA wipe descriptor, {MEM_WIPE, 0, 0, 0, 0}: written once,
    // then only read, by every engine's post-command wipe. HSM-owned like
    // the rings around it.
    upka_cmd_entry_t UPKA_WIPE_CMD       @ 0xAB610;
    bcp_dfl_entry_t  BCP_DFL[64]         @ 0xAB800 += 0x80;   // 0xAB800 - 0xAD800

    // One PKA command descriptor per staged-command ticket (the PKA
    // driver's TICKETS), written when the command is submitted, so that
    // the PKA interrupt handler starts a queued command on a freed engine
    // with one command-register write.
    upka_cmd_entry_t UPKA_TICKET_CMD[64] @ 0xAD800 += 0x14;   // 0xAD800 - 0xADD00

    // ─── FP bulk-key slot map: 65 × 1-byte table bitmaps ───
    fp_slot_map_t    FP_SLOT_MAP         @ 0xB8000;   // 0xB8000 - 0xB8041

    // ─── Partition persistent store (65 entries, 3072 B each) ───
    part_store_t     PART_STORE[65]      @ 0xBB000 += 0xC00;

    // ─── Key vault (65 typed tables, 8192 B each) ───
    key_vault_table_t KEY_VAULT[65]   @ 0xEBC00 += 0x2000;   // 65 × 8192 = 0x82000 → 0x16DC00

    // ─── HSM executable code (392 KB, 4 KB-aligned, up to FP_DSA_CACHE) ───
    hsm_code_t       HSM_CODE           @ 0x16E000;          // 0x16E000 - 0x1D0000

    // ─── Fastpath ML-DSA matrix cache (192 KB, ends GSRAM) ───
    fp_dsa_cache_t   FP_DSA_CACHE       @ 0x1D0000;          // 0x1D0000 - 0x200000
};
